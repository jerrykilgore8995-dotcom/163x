* THAT DN125 Fig 11, doc 600143 rev02. Independent circuit.
* R1=28.8k per page 8 text; ideal bench rails and source/load.
.param AMP=1.736 FREQ=1000 MORE=.5 MAKEUP=.5 SYM=.5
VPLUS VP 0 15
VMINUS VN 0 -15
VIN IN 0 SIN(0 {AMP} {FREQ})
C1 IN RMSAC 47u
R1 RMSAC RMSIN 28.8k
R5 IT VN 2meg
C4 CT 0 10u
R11 RMSOUT OA1M 6.04k
R2 OA1M OA1OUT 12k
RVR1A VP MOREW {100k*max(1e-6,1-MORE)}
RVR1B MOREW VN {100k*max(1e-6,MORE)}
R16 MOREW OA1M 810k
R15 MOREW PEM 810k
R4 PEM 0 12k
R3 OA1OUT NEM 12k
R14 VP NB 1.6meg
Q1 SUM NB NEM THATN
Q2 NB NB 0 THATN
R13 PB VN 1.6meg
Q3 PB PB 0 THATP
Q4 SUM PB PEM THATP
RVR2A VP MUW {10k*max(1e-6,1-MAKEUP)}
RVR2B MUW VN {10k*max(1e-6,MAKEUP)}
R17 MUW SUM 810k
R12 SUM EC 6.04k
C5 SUM EC 100n
C2 IN VCAAC 47u
R9 VCAAC VCAIN 20k
RVR10A VP SYMW {50k*max(1e-6,1-SYM)}
RVR10B SYMW VN {50k*max(1e-6,SYM)}
R7 SYMW SYMN 300k
R6 SYMN 0 51
C6 VP 0 22u
R8 VCAOUT OUT 20k
C3 VCAOUT OUT 47p
XU1 VCAIN 0 EC SYMN VCAOUT VP VN 0 0 OA1M OA1OUT 0 SUM EC OUT RMSIN IT CT RMSOUT THAT4301
RLOAD OUT 0 10k
.include vendor/4301_Macro_01.lib
.include vendor/array-selected.lib
.end
